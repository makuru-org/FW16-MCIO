** Profile: "LMQ644A2_Q1_STARTUP-Startup"  [ C:\Users\a0413388\Desktop\LMQ644A2-Q1_PSPICE_TRANS_EXAMPLE\lmq644a2-q1_trans-pspicefiles\lmq644a2_q1_startup\startup.sim ]

** Creating circuit file "Startup.cir"
** WARNING: THIS AUTOMATICALLY GENERATED FILE MAY BE OVERWRITTEN BY SUBSEQUENT SIMULATIONS

*Libraries:
* Profile Libraries :
* Local Libraries :
.LIB "../../../lmq644a2_q1_trans.lib"
* From [PSPICE NETLIST] section of C:\cds_spb_home\cdssetup\OrCAD_PSpiceTIPSpice_Install\17.4.0\PSpice.ini file:
.lib "nom_pspti.lib"
.lib "nom.lib"

*Analysis directives:
.TRAN  0 5m 0 10n
.OPTIONS ADVCONV
.OPTIONS FILEMODELSEARCH
.PROBE64 N([VLOAD])
.PROBE64 I(L_LOUT1)
.PROBE64 I(L_LOUT2)
.INC "..\LMQ644A2_Q1_STARTUP.net"

.END
